* Front end, nominal gain 32. Generated by model/daqmodel/spice.py,
* do not edit by hand: run scripts/run_all.py.
*
* Amplifiers are ideal VCVS; their noise allowances are injected by
* the resistor and VCCS generators marked NOISE below.
VCM src_n 0 DC 0
VSIG src_p src_n DC 0 AC 1
R1 src_p a_p 175
R2 src_n a_n 175
R3 a_p in_p 499
R4 a_n in_n 499
C1 in_p 0 1e-09
C2 in_n 0 1e-09
C3 in_p in_n 1e-08
* U1A: gain stage, zero drift
EU1A out_p 0 ni_u1a fb_p 1e+08
RNVU1A in_p ni_u1a 2171.81    ; NOISE e_n 6 nV/rtHz
RNIU1A ng_u1a 0 1000
GNIU1A 0 in_p ng_u1a 0 7.36852e-05    ; NOISE i_n 0.3 pA/rtHz
* U1B: gain stage, zero drift
EU1B out_n 0 ni_u1b fb_n 1e+08
RNVU1B in_n ni_u1b 2171.81    ; NOISE e_n 6 nV/rtHz
RNIU1B ng_u1b 0 1000
GNIU1B 0 in_n ng_u1b 0 7.36852e-05    ; NOISE i_n 0.3 pA/rtHz
R5 out_p fb_p 2490
R6 out_n fb_n 2490
R7 fb_p fb_n 162
R8 out_p ainp 499
R9 out_n ainm 499
C4 ainp 0 1e-09
C5 ainm 0 1e-09
C6 ainp ainm 1e-08
.control
noise v(ainp,ainm) VSIG dec 40 1 1e+07
setplot noise1
wrdata spice-out/noise_g32.dat onoise_spectrum
ac dec 40 1 1e+07
let vd = v(ainp) - v(ainm)
wrdata spice-out/ac_g32.dat mag(vd)
quit
.endc
.end
